* 8-cell column - text equivalent of the Xschem column symbol (8 sram8t_bitcell instances x1..x8).
* The pin order of the Xschem symbol may differ; the schematic in schematics/ is the reference.
* Shared per column: CL WBL WBLB ; per row: WWLi RWLi ; global: VDD PRE_B SHARE SHARE_B
.subckt sram8t_col CL VDD WBL WBLB PRE_B SHARE SHARE_B
+ WWL1 WWL2 WWL3 WWL4 WWL5 WWL6 WWL7 WWL8 RWL1 RWL2 RWL3 RWL4 RWL5 RWL6 RWL7 RWL8
x1 CL VDD WWL1 RWL1 WBL WBLB SHARE_B SHARE PRE_B sram8t_bitcell
x2 CL VDD WWL2 RWL2 WBL WBLB SHARE_B SHARE PRE_B sram8t_bitcell
x3 CL VDD WWL3 RWL3 WBL WBLB SHARE_B SHARE PRE_B sram8t_bitcell
x4 CL VDD WWL4 RWL4 WBL WBLB SHARE_B SHARE PRE_B sram8t_bitcell
x5 CL VDD WWL5 RWL5 WBL WBLB SHARE_B SHARE PRE_B sram8t_bitcell
x6 CL VDD WWL6 RWL6 WBL WBLB SHARE_B SHARE PRE_B sram8t_bitcell
x7 CL VDD WWL7 RWL7 WBL WBLB SHARE_B SHARE PRE_B sram8t_bitcell
x8 CL VDD WWL8 RWL8 WBL WBLB SHARE_B SHARE PRE_B sram8t_bitcell
.ends
* 8x4 array (xarr): four columns xc0..xc3 with own CL0..3 / WBL0..3 / WBLB0..3, shared WWL1..8, RWL1..8
