** sch_path: /home/blazeinkid/cim_project/schematics/untitled.sch
**.subckt untitled
x1 CL VDD WWL RWL1 WBL WBLB SHARE_B SHARE PRE_B sram8t_bitcell
**** begin user architecture code

.lib /usr/local/share/pdk/sky130A/libs.tech/ngspice/sky130.lib.spice fs

.param vdd_v=1.8
.param td=9.6e-9
.param t_r={10.2e-9+2e-11} t_f={10.2e-9+td} t_e={10.2e-9+td+2e-11}
.param kk=0
.param w1={kk>=1} w2={kk>=2} w3={kk>=3} w4={kk>=4} w5={kk>=5} w6={kk>=6} w7={kk>=7} w8={kk>=8}
.param in1=1 in2=1 in3=1 in4=1 in5=1 in6=1 in7=1 in8=1

x2 CL VDD WWL RWL2 WBL WBLB SHARE_B SHARE PRE_B sram8t_bitcell
x3 CL VDD WWL RWL3 WBL WBLB SHARE_B SHARE PRE_B sram8t_bitcell
x4 CL VDD WWL RWL4 WBL WBLB SHARE_B SHARE PRE_B sram8t_bitcell
x5 CL VDD WWL RWL5 WBL WBLB SHARE_B SHARE PRE_B sram8t_bitcell
x6 CL VDD WWL RWL6 WBL WBLB SHARE_B SHARE PRE_B sram8t_bitcell
x7 CL VDD WWL RWL7 WBL WBLB SHARE_B SHARE PRE_B sram8t_bitcell
x8 CL VDD WWL RWL8 WBL WBLB SHARE_B SHARE PRE_B sram8t_bitcell

.ic v(x1.q)={w1*vdd_v} v(x1.qb)={(1-w1)*vdd_v}
.ic v(x2.q)={w2*vdd_v} v(x2.qb)={(1-w2)*vdd_v}
.ic v(x3.q)={w3*vdd_v} v(x3.qb)={(1-w3)*vdd_v}
.ic v(x4.q)={w4*vdd_v} v(x4.qb)={(1-w4)*vdd_v}
.ic v(x5.q)={w5*vdd_v} v(x5.qb)={(1-w5)*vdd_v}
.ic v(x6.q)={w6*vdd_v} v(x6.qb)={(1-w6)*vdd_v}
.ic v(x7.q)={w7*vdd_v} v(x7.qb)={(1-w7)*vdd_v}
.ic v(x8.q)={w8*vdd_v} v(x8.qb)={(1-w8)*vdd_v}

Vsup  VDD   0 {vdd_v}
Vwwl  WWL   0 0
Vwbl  WBL   0 0
Vwblb WBLB  0 0
Vpre  PRE_B   0 PWL(0 0 9.9n 0 10n {vdd_v})
Vsh   SHARE   0 PWL(0 {vdd_v} 9.9n {vdd_v} 10n 0 19.9n 0 20n {vdd_v})
Vshb  SHARE_B 0 PWL(0 0 9.9n 0 10n {vdd_v} 19.9n {vdd_v} 20n 0)
Vr1 RWL1 0 PWL(0 0 10.2n 0 {t_r} {in1*vdd_v} {t_f} {in1*vdd_v} {t_e} 0)
Vr2 RWL2 0 PWL(0 0 10.2n 0 {t_r} {in2*vdd_v} {t_f} {in2*vdd_v} {t_e} 0)
Vr3 RWL3 0 PWL(0 0 10.2n 0 {t_r} {in3*vdd_v} {t_f} {in3*vdd_v} {t_e} 0)
Vr4 RWL4 0 PWL(0 0 10.2n 0 {t_r} {in4*vdd_v} {t_f} {in4*vdd_v} {t_e} 0)
Vr5 RWL5 0 PWL(0 0 10.2n 0 {t_r} {in5*vdd_v} {t_f} {in5*vdd_v} {t_e} 0)
Vr6 RWL6 0 PWL(0 0 10.2n 0 {t_r} {in6*vdd_v} {t_f} {in6*vdd_v} {t_e} 0)
Vr7 RWL7 0 PWL(0 0 10.2n 0 {t_r} {in7*vdd_v} {t_f} {in7*vdd_v} {t_e} 0)
Vr8 RWL8 0 PWL(0 0 10.2n 0 {t_r} {in8*vdd_v} {t_f} {in8*vdd_v} {t_e} 0)

.tran 0.01n 40n uic
.save v(CL)

.control
set cname = fs
foreach cc 1 2 3
  if $cc = 1
    set vv = 1.62
    set tv = 125
  end
  if $cc = 2
    set vv = 1.8
    set tv = 27
  end
  if $cc = 3
    set vv = 1.98
    set tv = -40
  end
  foreach tdv 9.6e-9 2e-9 1e-9 5e-10 3e-10 2e-10 1.5e-10 1e-10 7e-11
    foreach kv 0 8
      alterparam kk = $kv
      alterparam vdd_v = $vv
      alterparam td = $tdv
      set temp = $tv
      reset
      run
      meas tran vcl find v(cl) at=35n
      echo $cname $vv $tv $tdv $kv $&vcl >> td_results.csv
    end
  end
  echo finished $cname $vv $tv
end
.endc

**** end user architecture code
**.ends

* expanding   symbol:  sram8t_bitcell.sym # of pins=9
** sym_path: /home/blazeinkid/cim_project/schematics/sram8t_bitcell.sym
** sch_path: /home/blazeinkid/cim_project/schematics/sram8t_bitcell.sch
.subckt sram8t_bitcell CL VDD WWL RWL WBL WBLB SHARE_B SHARE PRE_B
*.ipin WBLB
*.ipin WBL
*.ipin RWL
*.ipin WWL
*.ipin VDD
*.ipin PRE_B
*.ipin CL
*.ipin SHARE
*.ipin SHARE_B
XM1 0 q qb 0 sky130_fd_pr__nfet_01v8 L=0.15 W=1 nf=1 ad=0.29 as=0.29 pd=2.58 ps=2.58 nrd=0.29 nrs=0.29 sa=0 sb=0 sd=0 mult=1
XM2 VDD q qb VDD sky130_fd_pr__pfet_01v8 L=0.15 W=1 nf=1 ad=0.29 as=0.29 pd=2.58 ps=2.58 nrd=0.29 nrs=0.29 sa=0 sb=0 sd=0 mult=1
XM3 q qb VDD VDD sky130_fd_pr__pfet_01v8 L=0.15 W=1 nf=1 ad=0.29 as=0.29 pd=2.58 ps=2.58 nrd=0.29 nrs=0.29 sa=0 sb=0 sd=0 mult=1
XM4 q qb 0 0 sky130_fd_pr__nfet_01v8 L=0.15 W=1 nf=1 ad=0.29 as=0.29 pd=2.58 ps=2.58 nrd=0.29 nrs=0.29 sa=0 sb=0 sd=0 mult=1
XM5 qb WWL WBLB 0 sky130_fd_pr__nfet_01v8 L=0.15 W=1 nf=1 ad=0.29 as=0.29 pd=2.58 ps=2.58 nrd=0.29 nrs=0.29 sa=0 sb=0 sd=0 mult=1
XM6 WBL WWL q 0 sky130_fd_pr__nfet_01v8 L=0.15 W=1 nf=1 ad=0.29 as=0.29 pd=2.58 ps=2.58 nrd=0.29 nrs=0.29 sa=0 sb=0 sd=0 mult=1
XM7 output q 0 0 sky130_fd_pr__nfet_01v8 L=0.15 W=1 nf=1 ad=0.29 as=0.29 pd=2.58 ps=2.58 nrd=0.29 nrs=0.29 sa=0 sb=0 sd=0 mult=1
XM8 net1 RWL output 0 sky130_fd_pr__nfet_01v8 L=0.15 W=1 nf=1 ad=0.29 as=0.29 pd=2.58 ps=2.58 nrd=0.29 nrs=0.29 sa=0 sb=0 sd=0
+ mult=1
C1 net1 0 10f
XM9 CL SHARE net1 0 sky130_fd_pr__nfet_01v8 L=0.15 W=1 nf=1 ad=0.29 as=0.29 pd=2.58 ps=2.58 nrd=0.29 nrs=0.29 sa=0 sb=0 sd=0
+ mult=1
XM10 net1 PRE_B VDD VDD sky130_fd_pr__pfet_01v8 L=0.15 W=1 nf=1 ad=0.29 as=0.29 pd=2.58 ps=2.58 nrd=0.29 nrs=0.29 sa=0 sb=0 sd=0
+ mult=1
XM11 CL SHARE_B net1 VDD sky130_fd_pr__pfet_01v8 L=0.15 W=1 nf=1 ad=0.29 as=0.29 pd=2.58 ps=2.58 nrd=0.29 nrs=0.29 sa=0 sb=0 sd=0
+ mult=1
.ends

.end
