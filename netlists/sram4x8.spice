** sch_path: /home/blazeinkid/cim_project/schematics/sram4x8.sch
**.subckt sram4x8
xarr CL1 CL2 CL3 WWL1 CL0 RWL1 WBL3 WBL0 WBL2 WBL1 VDD WBLB0 SHARE_B WBLB2 WBLB1 WBLB3 SHARE PRE_B WWL2 RWL2 WWL3 RWL3 WWL4 RWL4
+ WWL5 RWL5 WWL6 RWL6 WWL7 RWL7 WWL8 RWL8 sram_array
**** begin user architecture code

.lib /usr/local/share/pdk/sky130A/libs.tech/ngspice/sky130.lib.spice ss

.param vdd_v=1.8
.param tmp=27
.temp {tmp}
.param csig=0
.param td=0.5e-9
.param ts={10.5e-9+td}
.param pat=255
.param in1={floor(pat/1)-2*floor(pat/2)} in2={floor(pat/2)-2*floor(pat/4)}
.param in3={floor(pat/4)-2*floor(pat/8)} in4={floor(pat/8)-2*floor(pat/16)}
.param in5={floor(pat/16)-2*floor(pat/32)} in6={floor(pat/32)-2*floor(pat/64)}
.param in7={floor(pat/64)-2*floor(pat/128)} in8={floor(pat/128)-2*floor(pat/256)}

* weights w<row><col>, rows 1-8, cols 0-3
.param w10=1 w20=1 w30=1 w40=1 w50=1 w60=1 w70=1 w80=1
.param w11=1 w21=1 w31=1 w41=1 w51=0 w61=0 w71=0 w81=0
.param w12=1 w22=0 w32=1 w42=0 w52=1 w62=0 w72=1 w82=0
.param w13=0 w23=1 w33=1 w43=1 w53=1 w63=1 w73=0 w83=0

.ic v(xarr.xc0.x1.q)={w10*vdd_v} v(xarr.xc0.x1.qb)={(1-w10)*vdd_v}
.ic v(xarr.xc0.x2.q)={w20*vdd_v} v(xarr.xc0.x2.qb)={(1-w20)*vdd_v}
.ic v(xarr.xc0.x3.q)={w30*vdd_v} v(xarr.xc0.x3.qb)={(1-w30)*vdd_v}
.ic v(xarr.xc0.x4.q)={w40*vdd_v} v(xarr.xc0.x4.qb)={(1-w40)*vdd_v}
.ic v(xarr.xc0.x5.q)={w50*vdd_v} v(xarr.xc0.x5.qb)={(1-w50)*vdd_v}
.ic v(xarr.xc0.x6.q)={w60*vdd_v} v(xarr.xc0.x6.qb)={(1-w60)*vdd_v}
.ic v(xarr.xc0.x7.q)={w70*vdd_v} v(xarr.xc0.x7.qb)={(1-w70)*vdd_v}
.ic v(xarr.xc0.x8.q)={w80*vdd_v} v(xarr.xc0.x8.qb)={(1-w80)*vdd_v}
.ic v(xarr.xc1.x1.q)={w11*vdd_v} v(xarr.xc1.x1.qb)={(1-w11)*vdd_v}
.ic v(xarr.xc1.x2.q)={w21*vdd_v} v(xarr.xc1.x2.qb)={(1-w21)*vdd_v}
.ic v(xarr.xc1.x3.q)={w31*vdd_v} v(xarr.xc1.x3.qb)={(1-w31)*vdd_v}
.ic v(xarr.xc1.x4.q)={w41*vdd_v} v(xarr.xc1.x4.qb)={(1-w41)*vdd_v}
.ic v(xarr.xc1.x5.q)={w51*vdd_v} v(xarr.xc1.x5.qb)={(1-w51)*vdd_v}
.ic v(xarr.xc1.x6.q)={w61*vdd_v} v(xarr.xc1.x6.qb)={(1-w61)*vdd_v}
.ic v(xarr.xc1.x7.q)={w71*vdd_v} v(xarr.xc1.x7.qb)={(1-w71)*vdd_v}
.ic v(xarr.xc1.x8.q)={w81*vdd_v} v(xarr.xc1.x8.qb)={(1-w81)*vdd_v}
.ic v(xarr.xc2.x1.q)={w12*vdd_v} v(xarr.xc2.x1.qb)={(1-w12)*vdd_v}
.ic v(xarr.xc2.x2.q)={w22*vdd_v} v(xarr.xc2.x2.qb)={(1-w22)*vdd_v}
.ic v(xarr.xc2.x3.q)={w32*vdd_v} v(xarr.xc2.x3.qb)={(1-w32)*vdd_v}
.ic v(xarr.xc2.x4.q)={w42*vdd_v} v(xarr.xc2.x4.qb)={(1-w42)*vdd_v}
.ic v(xarr.xc2.x5.q)={w52*vdd_v} v(xarr.xc2.x5.qb)={(1-w52)*vdd_v}
.ic v(xarr.xc2.x6.q)={w62*vdd_v} v(xarr.xc2.x6.qb)={(1-w62)*vdd_v}
.ic v(xarr.xc2.x7.q)={w72*vdd_v} v(xarr.xc2.x7.qb)={(1-w72)*vdd_v}
.ic v(xarr.xc2.x8.q)={w82*vdd_v} v(xarr.xc2.x8.qb)={(1-w82)*vdd_v}
.ic v(xarr.xc3.x1.q)={w13*vdd_v} v(xarr.xc3.x1.qb)={(1-w13)*vdd_v}
.ic v(xarr.xc3.x2.q)={w23*vdd_v} v(xarr.xc3.x2.qb)={(1-w23)*vdd_v}
.ic v(xarr.xc3.x3.q)={w33*vdd_v} v(xarr.xc3.x3.qb)={(1-w33)*vdd_v}
.ic v(xarr.xc3.x4.q)={w43*vdd_v} v(xarr.xc3.x4.qb)={(1-w43)*vdd_v}
.ic v(xarr.xc3.x5.q)={w53*vdd_v} v(xarr.xc3.x5.qb)={(1-w53)*vdd_v}
.ic v(xarr.xc3.x6.q)={w63*vdd_v} v(xarr.xc3.x6.qb)={(1-w63)*vdd_v}
.ic v(xarr.xc3.x7.q)={w73*vdd_v} v(xarr.xc3.x7.qb)={(1-w73)*vdd_v}
.ic v(xarr.xc3.x8.q)={w83*vdd_v} v(xarr.xc3.x8.qb)={(1-w83)*vdd_v}

Vsup VDD 0 {vdd_v}
Vwbl0 WBL0 0 0
Vwblb0 WBLB0 0 0
Vwbl1 WBL1 0 0
Vwblb1 WBLB1 0 0
Vwbl2 WBL2 0 0
Vwblb2 WBLB2 0 0
Vwbl3 WBL3 0 0
Vwblb3 WBLB3 0 0
Vww1 WWL1 0 0
Vww2 WWL2 0 0
Vww3 WWL3 0 0
Vww4 WWL4 0 0
Vww5 WWL5 0 0
Vww6 WWL6 0 0
Vww7 WWL7 0 0
Vww8 WWL8 0 0

Vpre PRE_B 0 PWL(0 0 9.9n 0 10n {vdd_v})
Vsh SHARE 0 PWL(0 {vdd_v} 9.9n {vdd_v} 10n 0 {ts-0.1e-9} 0 {ts} {vdd_v})
Vshb SHARE_B 0 PWL(0 0 9.9n 0 10n {vdd_v} {ts-0.1e-9} {vdd_v} {ts} 0)

Vr1 RWL1 0 PWL(0 0 10.1n 0 10.2n {in1*vdd_v} {10.2e-9+td} {in1*vdd_v} {10.3e-9+td} 0)
Vr2 RWL2 0 PWL(0 0 10.1n 0 10.2n {in2*vdd_v} {10.2e-9+td} {in2*vdd_v} {10.3e-9+td} 0)
Vr3 RWL3 0 PWL(0 0 10.1n 0 10.2n {in3*vdd_v} {10.2e-9+td} {in3*vdd_v} {10.3e-9+td} 0)
Vr4 RWL4 0 PWL(0 0 10.1n 0 10.2n {in4*vdd_v} {10.2e-9+td} {in4*vdd_v} {10.3e-9+td} 0)
Vr5 RWL5 0 PWL(0 0 10.1n 0 10.2n {in5*vdd_v} {10.2e-9+td} {in5*vdd_v} {10.3e-9+td} 0)
Vr6 RWL6 0 PWL(0 0 10.1n 0 10.2n {in6*vdd_v} {10.2e-9+td} {in6*vdd_v} {10.3e-9+td} 0)
Vr7 RWL7 0 PWL(0 0 10.1n 0 10.2n {in7*vdd_v} {10.2e-9+td} {in7*vdd_v} {10.3e-9+td} 0)
Vr8 RWL8 0 PWL(0 0 10.1n 0 10.2n {in8*vdd_v} {10.2e-9+td} {in8*vdd_v} {10.3e-9+td} 0)

.tran 0.02n 16n uic
.save v(CL0) v(CL1) v(CL2) v(CL3)

.control
set cname = ss
foreach vv 1.62 1.8 1.98
  foreach tv -40 27 125
    foreach pv 255 173 0 170 85 15 240 1 127 118 201 60
      alterparam vdd_v=$vv
      alterparam tmp=$tv
      alterparam pat=$pv
      reset
      run
      meas tran c0 find v(cl0) at=13n
      meas tran c1 find v(cl1) at=13n
      meas tran c2 find v(cl2) at=13n
      meas tran c3 find v(cl3) at=13n
      echo $cname $vv $tv $pv $&c0 $&c1 $&c2 $&c3 >> array_pvt.csv
    end
  end
end
.endc

**** end user architecture code
**.ends

* expanding   symbol:  sram_array.sym # of pins=32
** sym_path: /home/blazeinkid/cim_project/schematics/sram_array.sym
** sch_path: /home/blazeinkid/cim_project/schematics/sram_array.sch
.subckt sram_array CL1 CL2 CL3 WWL1 CL0 RWL1 WBL3 WBL0 WBL2 WBL1 VDD WBLB0 SHARE_B WBLB2 WBLB1 WBLB3 SHARE PRE_B WWL2 RWL2 WWL3
+ RWL3 WWL4 RWL4 WWL5 RWL5 WWL6 RWL6 WWL7 RWL7 WWL8 RWL8
*.ipin WWL1
*.ipin RWL1
*.ipin WBL0
*.ipin WBLB0
*.ipin SHARE_B
*.ipin SHARE
*.ipin PRE_B
*.ipin WWL2
*.ipin RWL2
*.ipin WWL3
*.ipin RWL3
*.ipin WWL4
*.ipin RWL4
*.ipin WWL5
*.ipin RWL5
*.ipin WWL6
*.ipin RWL6
*.ipin WWL7
*.ipin RWL7
*.ipin WWL8
*.ipin RWL8
*.iopin VDD
*.opin CL0
*.opin CL1
*.opin CL2
*.opin CL3
*.ipin WBL1
*.ipin WBL2
*.ipin WBL3
*.ipin WBLB1
*.ipin WBLB2
*.ipin WBLB3
xc0 CL0 VDD WWL1 RWL1 WBL0 WBLB0 SHARE_B SHARE PRE_B WWL2 RWL2 WWL3 RWL3 WWL4 RWL4 WWL5 RWL5 WWL6 RWL6 WWL7 RWL7 WWL8 RWL8
+ column8t
xc1 CL1 VDD WWL1 RWL1 WBL1 WBLB1 SHARE_B SHARE PRE_B WWL2 RWL2 WWL3 RWL3 WWL4 RWL4 WWL5 RWL5 WWL6 RWL6 WWL7 RWL7 WWL8 RWL8
+ column8t
xc2 CL2 VDD WWL1 RWL1 WBL2 WBLB2 SHARE_B SHARE PRE_B WWL2 RWL2 WWL3 RWL3 WWL4 RWL4 WWL5 RWL5 WWL6 RWL6 WWL7 RWL7 WWL8 RWL8
+ column8t
xc3 CL3 VDD WWL1 RWL1 WBL3 WBLB3 SHARE_B SHARE PRE_B WWL2 RWL2 WWL3 RWL3 WWL4 RWL4 WWL5 RWL5 WWL6 RWL6 WWL7 RWL7 WWL8 RWL8
+ column8t
.ends

* expanding   symbol:  column8t.sym # of pins=23
** sym_path: /home/blazeinkid/cim_project/schematics/column8t.sym
** sch_path: /home/blazeinkid/cim_project/schematics/column8t.sch
.subckt column8t CL VDD WWL1 RWL1 WBL WBLB SHARE_B SHARE PRE_B WWL2 RWL2 WWL3 RWL3 WWL4 RWL4 WWL5 RWL5 WWL6 RWL6 WWL7 RWL7 WWL8
+ RWL8
*.iopin VDD
*.ipin WBL
*.ipin WBLB
*.ipin SHARE_B
*.ipin SHARE
*.ipin PRE_B
*.opin CL
*.ipin WWL1
*.ipin RWL1
*.ipin WWL2
*.ipin RWL2
*.ipin WWL3
*.ipin RWL3
*.ipin WWL4
*.ipin RWL4
*.ipin WWL5
*.ipin RWL5
*.ipin WWL6
*.ipin RWL6
*.ipin WWL7
*.ipin RWL7
*.ipin WWL8
*.ipin RWL8
x1 CL VDD WWL1 RWL1 WBL WBLB SHARE_B SHARE PRE_B sram8t_bitcell
x2 CL VDD WWL2 RWL2 WBL WBLB SHARE_B SHARE PRE_B sram8t_bitcell
x3 CL VDD WWL3 RWL3 WBL WBLB SHARE_B SHARE PRE_B sram8t_bitcell
x4 CL VDD WWL4 RWL4 WBL WBLB SHARE_B SHARE PRE_B sram8t_bitcell
x5 CL VDD WWL5 RWL5 WBL WBLB SHARE_B SHARE PRE_B sram8t_bitcell
x6 CL VDD WWL6 RWL6 WBL WBLB SHARE_B SHARE PRE_B sram8t_bitcell
x7 CL VDD WWL7 RWL7 WBL WBLB SHARE_B SHARE PRE_B sram8t_bitcell
x8 CL VDD WWL8 RWL8 WBL WBLB SHARE_B SHARE PRE_B sram8t_bitcell
.ends

* expanding   symbol:  sram8t_bitcell.sym # of pins=9
** sym_path: /home/blazeinkid/cim_project/schematics/sram8t_bitcell.sym
** sch_path: /home/blazeinkid/cim_project/schematics/sram8t_bitcell.sch
.subckt sram8t_bitcell CL VDD WWL RWL WBL WBLB SHARE_B SHARE PRE_B
*.ipin WBLB
*.ipin WBL
*.ipin RWL
*.ipin WWL
*.ipin VDD
*.ipin PRE_B
*.ipin CL
*.ipin SHARE
*.ipin SHARE_B
XM1 0 q qb 0 sky130_fd_pr__nfet_01v8 L=0.15 W=1 nf=1 ad=0.29 as=0.29 pd=2.58 ps=2.58 nrd=0.29 nrs=0.29 sa=0 sb=0 sd=0 mult=1
XM2 VDD q qb VDD sky130_fd_pr__pfet_01v8 L=0.15 W=1 nf=1 ad=0.29 as=0.29 pd=2.58 ps=2.58 nrd=0.29 nrs=0.29 sa=0 sb=0 sd=0 mult=1
XM3 q qb VDD VDD sky130_fd_pr__pfet_01v8 L=0.15 W=1 nf=1 ad=0.29 as=0.29 pd=2.58 ps=2.58 nrd=0.29 nrs=0.29 sa=0 sb=0 sd=0 mult=1
XM4 q qb 0 0 sky130_fd_pr__nfet_01v8 L=0.15 W=1 nf=1 ad=0.29 as=0.29 pd=2.58 ps=2.58 nrd=0.29 nrs=0.29 sa=0 sb=0 sd=0 mult=1
XM5 qb WWL WBLB 0 sky130_fd_pr__nfet_01v8 L=0.15 W=1 nf=1 ad=0.29 as=0.29 pd=2.58 ps=2.58 nrd=0.29 nrs=0.29 sa=0 sb=0 sd=0 mult=1
XM6 WBL WWL q 0 sky130_fd_pr__nfet_01v8 L=0.15 W=1 nf=1 ad=0.29 as=0.29 pd=2.58 ps=2.58 nrd=0.29 nrs=0.29 sa=0 sb=0 sd=0 mult=1
XM7 output q 0 0 sky130_fd_pr__nfet_01v8 L=0.15 W=1 nf=1 ad=0.29 as=0.29 pd=2.58 ps=2.58 nrd=0.29 nrs=0.29 sa=0 sb=0 sd=0 mult=1
XM8 net1 RWL output 0 sky130_fd_pr__nfet_01v8 L=0.15 W=1 nf=1 ad=0.29 as=0.29 pd=2.58 ps=2.58 nrd=0.29 nrs=0.29 sa=0 sb=0 sd=0
+ mult=1
C1 net1 0 10f
XM9 CL SHARE net1 0 sky130_fd_pr__nfet_01v8 L=0.15 W=1 nf=1 ad=0.29 as=0.29 pd=2.58 ps=2.58 nrd=0.29 nrs=0.29 sa=0 sb=0 sd=0
+ mult=1
XM10 net1 PRE_B VDD VDD sky130_fd_pr__pfet_01v8 L=0.15 W=1 nf=1 ad=0.29 as=0.29 pd=2.58 ps=2.58 nrd=0.29 nrs=0.29 sa=0 sb=0 sd=0
+ mult=1
XM11 CL SHARE_B net1 VDD sky130_fd_pr__pfet_01v8 L=0.15 W=1 nf=1 ad=0.29 as=0.29 pd=2.58 ps=2.58 nrd=0.29 nrs=0.29 sa=0 sb=0 sd=0
+ mult=1
.ends

.end
